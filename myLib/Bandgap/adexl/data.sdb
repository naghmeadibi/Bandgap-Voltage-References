ADE simulation setup
Run mode: Monte Carlo Sampling
Tests:
  myLib:Bandgap:1: myLib/Bandgap/schematic, simulator spectre
Global variables:
  vdd = 1.5
Monte Carlo Sampling options: mcmethod=mismatch, mcnumpoints=200
