ADE simulation setup
Run mode: Monte Carlo Sampling
Tests:
  myLib:Bandgap_Mismatch:1: myLib/Bandgap_Mismatch/schematic, simulator spectre
Global variables:
  vdd = 1.5
Monte Carlo Sampling options: mcmethod=all, mcnumpoints=100
