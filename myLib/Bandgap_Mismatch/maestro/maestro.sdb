ADE simulation setup
Run mode: Monte Carlo Sampling
Tests:
  myLib:Bandgap_Mismatch:1: myLib/Bandgap_Mismatch/schematic, simulator spectre
Monte Carlo Sampling options: mcmethod=all, mcnumpoints=200
