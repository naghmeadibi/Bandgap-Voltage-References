ADE simulation setup
Test myLib:Bandgap_Mismatch:1: myLib/Bandgap_Mismatch/schematic, simulator spectre
  Models: /home/user1/env65lp/tsmcN65/../models/spectre/toplevel.scs[mismatch_lib]
  Temperature: 27
  Analysis dc: sweep temperature start=-40 stop=150 step=500 (saves the operating point)
Run mode: Monte Carlo Sampling
Monte Carlo Sampling options: mcmethod=all, mcnumpoints=200
